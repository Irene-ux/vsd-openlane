* SPICE3 file created from sky130_inv.ext - technology: sky130A
.option scale=0.01u
.include ./libs/pshort.lib
.include ./libs/nshort.lib
M0 Y A VGND VGND nshort_model.0 ad=1.435n pd=0.152m as=1.365n ps=0.148m w=35 l=23
M1 Y A VPWR VPWR pshort_model.0 ad=1.443n pd=0.152m as=1.517n ps=0.156m w=37 l=23
C0 A Y 0.05538f
C1 Y VPWR 0.09712f
C2 A VPWR 0.20103f
C3 Y VGND 0.16453f
C4 A VGND 0.23472f
C5 VPWR VGND 0.6652f
VDD VPWR 0 3.3V
VSS VGND 0 0V
Va A VGND PULSE(0 3.3V 0 0.1ns 0.1ns 2ns 4ns)
.tran 1n 20n
.control
run
.endc
.end
